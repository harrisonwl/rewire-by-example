* SPICE netlist generated by Yosys 0.54 (git sha1 db72ec3bde296a9512b2d1e6fabf81cfb07c2c1b, clang++ 17.0.0 -fPIC -O3)

.SUBCKT Main_fibgen arg0.0 arg0.1 arg0.2 arg0.3 arg0.4 arg0.5 arg0.6 arg0.7 arg1.0 arg1.1 arg1.2 arg1.3 arg1.4 arg1.5 arg1.6 arg1.7 res.0 res.1 res.2 res.3 res.4 res.5 res.6 res.7 res.8 res.9 res.10 res.11 res.12 res.13 res.14 res.15 res.16 res.17 res.18 res.19 res.20 res.21 res.22 res.23
V0 arg1.0 res.0 DC 0
V1 arg1.1 res.1 DC 0
V2 arg1.2 res.2 DC 0
V3 arg1.3 res.3 DC 0
V4 arg1.4 res.4 DC 0
V5 arg1.5 res.5 DC 0
V6 arg1.6 res.6 DC 0
V7 arg1.7 res.7 DC 0
V8 arg0.0 res.8 DC 0
V9 arg0.1 res.9 DC 0
V10 arg0.2 res.10 DC 0
V11 arg0.3 res.11 DC 0
V12 arg0.4 res.12 DC 0
V13 arg0.5 res.13 DC 0
V14 arg0.6 res.14 DC 0
V15 arg0.7 res.15 DC 0
V16 arg0.0 res.16 DC 0
V17 arg0.1 res.17 DC 0
V18 arg0.2 res.18 DC 0
V19 arg0.3 res.19 DC 0
V20 arg0.4 res.20 DC 0
V21 arg0.5 res.21 DC 0
V22 arg0.6 res.22 DC 0
V23 arg0.7 res.23 DC 0
V24 arg1.0 zll_main_fibgen3_in.0 DC 0
V25 arg1.1 zll_main_fibgen3_in.1 DC 0
V26 arg1.2 zll_main_fibgen3_in.2 DC 0
V27 arg1.3 zll_main_fibgen3_in.3 DC 0
V28 arg1.4 zll_main_fibgen3_in.4 DC 0
V29 arg1.5 zll_main_fibgen3_in.5 DC 0
V30 arg1.6 zll_main_fibgen3_in.6 DC 0
V31 arg1.7 zll_main_fibgen3_in.7 DC 0
V32 arg0.0 zll_main_fibgen3_in.8 DC 0
V33 arg0.1 zll_main_fibgen3_in.9 DC 0
V34 arg0.2 zll_main_fibgen3_in.10 DC 0
V35 arg0.3 zll_main_fibgen3_in.11 DC 0
V36 arg0.4 zll_main_fibgen3_in.12 DC 0
V37 arg0.5 zll_main_fibgen3_in.13 DC 0
V38 arg0.6 zll_main_fibgen3_in.14 DC 0
V39 arg0.7 zll_main_fibgen3_in.15 DC 0
V40 arg1.0 zll_main_fibgen9_in.0 DC 0
V41 arg1.1 zll_main_fibgen9_in.1 DC 0
V42 arg1.2 zll_main_fibgen9_in.2 DC 0
V43 arg1.3 zll_main_fibgen9_in.3 DC 0
V44 arg1.4 zll_main_fibgen9_in.4 DC 0
V45 arg1.5 zll_main_fibgen9_in.5 DC 0
V46 arg1.6 zll_main_fibgen9_in.6 DC 0
V47 arg1.7 zll_main_fibgen9_in.7 DC 0
V48 arg0.0 zll_main_fibgen9_in.8 DC 0
V49 arg0.1 zll_main_fibgen9_in.9 DC 0
V50 arg0.2 zll_main_fibgen9_in.10 DC 0
V51 arg0.3 zll_main_fibgen9_in.11 DC 0
V52 arg0.4 zll_main_fibgen9_in.12 DC 0
V53 arg0.5 zll_main_fibgen9_in.13 DC 0
V54 arg0.6 zll_main_fibgen9_in.14 DC 0
V55 arg0.7 zll_main_fibgen9_in.15 DC 0
.ENDS Main_fibgen

X0 main_fibgen_out.0 main_fibgen_outR1.0 __in0 __resumption_tag_next.0 __MUX_
X1 main_fibgen_out.1 main_fibgen_outR1.1 __in0 __resumption_tag_next.1 __MUX_
X2 main_fibgen_out.2 main_fibgen_outR1.2 __in0 __resumption_tag_next.2 __MUX_
X3 main_fibgen_out.3 main_fibgen_outR1.3 __in0 __resumption_tag_next.3 __MUX_
X4 main_fibgen_out.4 main_fibgen_outR1.4 __in0 __resumption_tag_next.4 __MUX_
X5 main_fibgen_out.5 main_fibgen_outR1.5 __in0 __resumption_tag_next.5 __MUX_
X6 main_fibgen_out.6 main_fibgen_outR1.6 __in0 __resumption_tag_next.6 __MUX_
X7 main_fibgen_out.7 main_fibgen_outR1.7 __in0 __resumption_tag_next.7 __MUX_
X8 main_fibgen_out.8 main_fibgen_outR1.8 __in0 __resumption_tag_next.8 __MUX_
X9 main_fibgen_out.9 main_fibgen_outR1.9 __in0 __resumption_tag_next.9 __MUX_
X10 main_fibgen_out.10 main_fibgen_outR1.10 __in0 __resumption_tag_next.10 __MUX_
X11 main_fibgen_out.11 main_fibgen_outR1.11 __in0 __resumption_tag_next.11 __MUX_
X12 main_fibgen_out.12 main_fibgen_outR1.12 __in0 __resumption_tag_next.12 __MUX_
X13 main_fibgen_out.13 main_fibgen_outR1.13 __in0 __resumption_tag_next.13 __MUX_
X14 main_fibgen_out.14 main_fibgen_outR1.14 __in0 __resumption_tag_next.14 __MUX_
X15 main_fibgen_out.15 main_fibgen_outR1.15 __in0 __resumption_tag_next.15 __MUX_
X16 main_fibgen_out.16 main_fibgen_outR1.16 __in0 __out0.0 __MUX_
X17 main_fibgen_out.17 main_fibgen_outR1.17 __in0 __out0.1 __MUX_
X18 main_fibgen_out.18 main_fibgen_outR1.18 __in0 __out0.2 __MUX_
X19 main_fibgen_out.19 main_fibgen_outR1.19 __in0 __out0.3 __MUX_
X20 main_fibgen_out.20 main_fibgen_outR1.20 __in0 __out0.4 __MUX_
X21 main_fibgen_out.21 main_fibgen_outR1.21 __in0 __out0.5 __MUX_
X22 main_fibgen_out.22 main_fibgen_outR1.22 __in0 __out0.6 __MUX_
X23 main_fibgen_out.23 main_fibgen_outR1.23 __in0 __out0.7 __MUX_
X24 __resumption_tag.1 __resumption_tag.9 1 __XOR_
X25 __resumption_tag.0 __resumption_tag.8 2 __NAND_
X26 2 1 main_fibgen_in.1 __XNOR_
X27 __resumption_tag.2 __resumption_tag.10 3 __XNOR_
X28 __resumption_tag.1 __resumption_tag.9 4 __AND_
X29 1 2 5 __ANDNOT_
X30 5 4 6 __OR_
X31 6 3 main_fibgen_in.2 __XNOR_
X32 __resumption_tag.3 __resumption_tag.11 7 __XNOR_
X33 __resumption_tag.2 __resumption_tag.10 8 __NAND_
X34 6 3 9 __ANDNOT_
X35 8 9 10 __ANDNOT_
X36 10 7 main_fibgen_in.3 __XOR_
X37 __resumption_tag.4 __resumption_tag.12 11 __XNOR_
X38 __resumption_tag.3 __resumption_tag.11 12 __NAND_
X39 8 7 13 __NOR_
X40 12 13 14 __ANDNOT_
X41 7 3 15 __OR_
X42 6 15 16 __ANDNOT_
X43 14 16 17 __ANDNOT_
X44 17 11 main_fibgen_in.4 __XOR_
X45 __resumption_tag.5 __resumption_tag.13 18 __XNOR_
X46 __resumption_tag.4 __resumption_tag.12 19 __NAND_
X47 17 11 20 __NOR_
X48 19 20 21 __ANDNOT_
X49 21 18 main_fibgen_in.5 __XOR_
X50 __resumption_tag.6 __resumption_tag.14 22 __XNOR_
X51 __resumption_tag.5 __resumption_tag.13 23 __NAND_
X52 19 18 24 __NOR_
X53 23 24 25 __ANDNOT_
X54 18 11 26 __OR_
X55 26 17 27 __NOR_
X56 25 27 28 __ANDNOT_
X57 28 22 main_fibgen_in.6 __XOR_
X58 __resumption_tag.7 __resumption_tag.15 29 __XNOR_
X59 __resumption_tag.6 __resumption_tag.14 30 __NAND_
X60 28 22 31 __NOR_
X61 30 31 32 __ANDNOT_
X62 32 29 main_fibgen_in.7 __XOR_
X63 __resumption_tag.0 __resumption_tag.8 main_fibgen_in.0 __XOR_
X64 clk __resumption_tag_next.10 __resumption_tag.10 rst __DFF_PP0_
X65 clk __resumption_tag_next.11 __resumption_tag.11 rst __DFF_PP0_
X66 clk __resumption_tag_next.12 __resumption_tag.12 rst __DFF_PP0_
X67 clk __resumption_tag_next.13 __resumption_tag.13 rst __DFF_PP0_
X68 clk __resumption_tag_next.14 __resumption_tag.14 rst __DFF_PP0_
X69 clk __resumption_tag_next.15 __resumption_tag.15 rst __DFF_PP0_
X70 clk __resumption_tag_next.0 __resumption_tag.0 rst __DFF_PP1_
X71 clk __resumption_tag_next.1 __resumption_tag.1 rst __DFF_PP0_
X72 clk __resumption_tag_next.2 __resumption_tag.2 rst __DFF_PP0_
X73 clk __resumption_tag_next.3 __resumption_tag.3 rst __DFF_PP0_
X74 clk __resumption_tag_next.4 __resumption_tag.4 rst __DFF_PP0_
X75 clk __resumption_tag_next.5 __resumption_tag.5 rst __DFF_PP0_
X76 clk __resumption_tag_next.6 __resumption_tag.6 rst __DFF_PP0_
X77 clk __resumption_tag_next.7 __resumption_tag.7 rst __DFF_PP0_
X78 clk __resumption_tag_next.8 __resumption_tag.8 rst __DFF_PP0_
X79 clk __resumption_tag_next.9 __resumption_tag.9 rst __DFF_PP0_
X80 __resumption_tag.0 __resumption_tag.1 __resumption_tag.2 __resumption_tag.3 __resumption_tag.4 __resumption_tag.5 __resumption_tag.6 __resumption_tag.7 main_fibgen_in.0 main_fibgen_in.1 main_fibgen_in.2 main_fibgen_in.3 main_fibgen_in.4 main_fibgen_in.5 main_fibgen_in.6 main_fibgen_in.7 main_fibgen_out.0 main_fibgen_out.1 main_fibgen_out.2 main_fibgen_out.3 main_fibgen_out.4 main_fibgen_out.5 main_fibgen_out.6 main_fibgen_out.7 main_fibgen_out.8 main_fibgen_out.9 main_fibgen_out.10 main_fibgen_out.11 main_fibgen_out.12 main_fibgen_out.13 main_fibgen_out.14 main_fibgen_out.15 main_fibgen_out.16 main_fibgen_out.17 main_fibgen_out.18 main_fibgen_out.19 main_fibgen_out.20 main_fibgen_out.21 main_fibgen_out.22 main_fibgen_out.23 Main_fibgen
X81 __resumption_tag.8 __resumption_tag.9 __resumption_tag.10 __resumption_tag.11 __resumption_tag.12 __resumption_tag.13 __resumption_tag.14 __resumption_tag.15 __resumption_tag.0 __resumption_tag.1 __resumption_tag.2 __resumption_tag.3 __resumption_tag.4 __resumption_tag.5 __resumption_tag.6 __resumption_tag.7 main_fibgen_outR1.0 main_fibgen_outR1.1 main_fibgen_outR1.2 main_fibgen_outR1.3 main_fibgen_outR1.4 main_fibgen_outR1.5 main_fibgen_outR1.6 main_fibgen_outR1.7 main_fibgen_outR1.8 main_fibgen_outR1.9 main_fibgen_outR1.10 main_fibgen_outR1.11 main_fibgen_outR1.12 main_fibgen_outR1.13 main_fibgen_outR1.14 main_fibgen_outR1.15 main_fibgen_outR1.16 main_fibgen_outR1.17 main_fibgen_outR1.18 main_fibgen_outR1.19 main_fibgen_outR1.20 main_fibgen_outR1.21 main_fibgen_outR1.22 main_fibgen_outR1.23 Main_fibgen
V0 Vss __continue DC 0
V1 __resumption_tag.0 binop_in.0 DC 0
V2 __resumption_tag.1 binop_in.1 DC 0
V3 __resumption_tag.2 binop_in.2 DC 0
V4 __resumption_tag.3 binop_in.3 DC 0
V5 __resumption_tag.4 binop_in.4 DC 0
V6 __resumption_tag.5 binop_in.5 DC 0
V7 __resumption_tag.6 binop_in.6 DC 0
V8 __resumption_tag.7 binop_in.7 DC 0
V9 __resumption_tag.8 binop_in.8 DC 0
V10 __resumption_tag.9 binop_in.9 DC 0
V11 __resumption_tag.10 binop_in.10 DC 0
V12 __resumption_tag.11 binop_in.11 DC 0
V13 __resumption_tag.12 binop_in.12 DC 0
V14 __resumption_tag.13 binop_in.13 DC 0
V15 __resumption_tag.14 binop_in.14 DC 0
V16 __resumption_tag.15 binop_in.15 DC 0
V17 __resumption_tag.0 main_fibgen_in.8 DC 0
V18 __resumption_tag.1 main_fibgen_in.9 DC 0
V19 __resumption_tag.2 main_fibgen_in.10 DC 0
V20 __resumption_tag.3 main_fibgen_in.11 DC 0
V21 __resumption_tag.4 main_fibgen_in.12 DC 0
V22 __resumption_tag.5 main_fibgen_in.13 DC 0
V23 __resumption_tag.6 main_fibgen_in.14 DC 0
V24 __resumption_tag.7 main_fibgen_in.15 DC 0
V25 __resumption_tag.0 main_fibgen_inR1.0 DC 0
V26 __resumption_tag.1 main_fibgen_inR1.1 DC 0
V27 __resumption_tag.2 main_fibgen_inR1.2 DC 0
V28 __resumption_tag.3 main_fibgen_inR1.3 DC 0
V29 __resumption_tag.4 main_fibgen_inR1.4 DC 0
V30 __resumption_tag.5 main_fibgen_inR1.5 DC 0
V31 __resumption_tag.6 main_fibgen_inR1.6 DC 0
V32 __resumption_tag.7 main_fibgen_inR1.7 DC 0
V33 __resumption_tag.8 main_fibgen_inR1.8 DC 0
V34 __resumption_tag.9 main_fibgen_inR1.9 DC 0
V35 __resumption_tag.10 main_fibgen_inR1.10 DC 0
V36 __resumption_tag.11 main_fibgen_inR1.11 DC 0
V37 __resumption_tag.12 main_fibgen_inR1.12 DC 0
V38 __resumption_tag.13 main_fibgen_inR1.13 DC 0
V39 __resumption_tag.14 main_fibgen_inR1.14 DC 0
V40 __resumption_tag.15 main_fibgen_inR1.15 DC 0
V41 __in0 zll_main_fibgen11_in.0 DC 0
V42 __resumption_tag.0 zll_main_fibgen11_in.1 DC 0
V43 __resumption_tag.1 zll_main_fibgen11_in.2 DC 0
V44 __resumption_tag.2 zll_main_fibgen11_in.3 DC 0
V45 __resumption_tag.3 zll_main_fibgen11_in.4 DC 0
V46 __resumption_tag.4 zll_main_fibgen11_in.5 DC 0
V47 __resumption_tag.5 zll_main_fibgen11_in.6 DC 0
V48 __resumption_tag.6 zll_main_fibgen11_in.7 DC 0
V49 __resumption_tag.7 zll_main_fibgen11_in.8 DC 0
V50 __resumption_tag.8 zll_main_fibgen11_in.9 DC 0
V51 __resumption_tag.9 zll_main_fibgen11_in.10 DC 0
V52 __resumption_tag.10 zll_main_fibgen11_in.11 DC 0
V53 __resumption_tag.11 zll_main_fibgen11_in.12 DC 0
V54 __resumption_tag.12 zll_main_fibgen11_in.13 DC 0
V55 __resumption_tag.13 zll_main_fibgen11_in.14 DC 0
V56 __resumption_tag.14 zll_main_fibgen11_in.15 DC 0
V57 __resumption_tag.15 zll_main_fibgen11_in.16 DC 0
V58 __in0 zll_main_fibgen2_in.0 DC 0
V59 __resumption_tag.0 zll_main_fibgen2_in.1 DC 0
V60 __resumption_tag.1 zll_main_fibgen2_in.2 DC 0
V61 __resumption_tag.2 zll_main_fibgen2_in.3 DC 0
V62 __resumption_tag.3 zll_main_fibgen2_in.4 DC 0
V63 __resumption_tag.4 zll_main_fibgen2_in.5 DC 0
V64 __resumption_tag.5 zll_main_fibgen2_in.6 DC 0
V65 __resumption_tag.6 zll_main_fibgen2_in.7 DC 0
V66 __resumption_tag.7 zll_main_fibgen2_in.8 DC 0
V67 __resumption_tag.8 zll_main_fibgen2_in.9 DC 0
V68 __resumption_tag.9 zll_main_fibgen2_in.10 DC 0
V69 __resumption_tag.10 zll_main_fibgen2_in.11 DC 0
V70 __resumption_tag.11 zll_main_fibgen2_in.12 DC 0
V71 __resumption_tag.12 zll_main_fibgen2_in.13 DC 0
V72 __resumption_tag.13 zll_main_fibgen2_in.14 DC 0
V73 __resumption_tag.14 zll_main_fibgen2_in.15 DC 0
V74 __resumption_tag.15 zll_main_fibgen2_in.16 DC 0
V75 __in0 zll_main_fibgen4_in.0 DC 0
V76 __resumption_tag.0 zll_main_fibgen4_in.1 DC 0
V77 __resumption_tag.1 zll_main_fibgen4_in.2 DC 0
V78 __resumption_tag.2 zll_main_fibgen4_in.3 DC 0
V79 __resumption_tag.3 zll_main_fibgen4_in.4 DC 0
V80 __resumption_tag.4 zll_main_fibgen4_in.5 DC 0
V81 __resumption_tag.5 zll_main_fibgen4_in.6 DC 0
V82 __resumption_tag.6 zll_main_fibgen4_in.7 DC 0
V83 __resumption_tag.7 zll_main_fibgen4_in.8 DC 0
V84 __resumption_tag.8 zll_main_fibgen4_in.9 DC 0
V85 __resumption_tag.9 zll_main_fibgen4_in.10 DC 0
V86 __resumption_tag.10 zll_main_fibgen4_in.11 DC 0
V87 __resumption_tag.11 zll_main_fibgen4_in.12 DC 0
V88 __resumption_tag.12 zll_main_fibgen4_in.13 DC 0
V89 __resumption_tag.13 zll_main_fibgen4_in.14 DC 0
V90 __resumption_tag.14 zll_main_fibgen4_in.15 DC 0
V91 __resumption_tag.15 zll_main_fibgen4_in.16 DC 0
V92 __in0 zll_main_fibgen6_in.0 DC 0
V93 __resumption_tag.0 zll_main_fibgen6_in.1 DC 0
V94 __resumption_tag.1 zll_main_fibgen6_in.2 DC 0
V95 __resumption_tag.2 zll_main_fibgen6_in.3 DC 0
V96 __resumption_tag.3 zll_main_fibgen6_in.4 DC 0
V97 __resumption_tag.4 zll_main_fibgen6_in.5 DC 0
V98 __resumption_tag.5 zll_main_fibgen6_in.6 DC 0
V99 __resumption_tag.6 zll_main_fibgen6_in.7 DC 0
V100 __resumption_tag.7 zll_main_fibgen6_in.8 DC 0
V101 __resumption_tag.8 zll_main_fibgen6_in.9 DC 0
V102 __resumption_tag.9 zll_main_fibgen6_in.10 DC 0
V103 __resumption_tag.10 zll_main_fibgen6_in.11 DC 0
V104 __resumption_tag.11 zll_main_fibgen6_in.12 DC 0
V105 __resumption_tag.12 zll_main_fibgen6_in.13 DC 0
V106 __resumption_tag.13 zll_main_fibgen6_in.14 DC 0
V107 __resumption_tag.14 zll_main_fibgen6_in.15 DC 0
V108 __resumption_tag.15 zll_main_fibgen6_in.16 DC 0
V109 __resumption_tag.0 zll_main_fibgen8_in.0 DC 0
V110 __resumption_tag.1 zll_main_fibgen8_in.1 DC 0
V111 __resumption_tag.2 zll_main_fibgen8_in.2 DC 0
V112 __resumption_tag.3 zll_main_fibgen8_in.3 DC 0
V113 __resumption_tag.4 zll_main_fibgen8_in.4 DC 0
V114 __resumption_tag.5 zll_main_fibgen8_in.5 DC 0
V115 __resumption_tag.6 zll_main_fibgen8_in.6 DC 0
V116 __resumption_tag.7 zll_main_fibgen8_in.7 DC 0
V117 __resumption_tag.8 zll_main_fibgen8_in.8 DC 0
V118 __resumption_tag.9 zll_main_fibgen8_in.9 DC 0
V119 __resumption_tag.10 zll_main_fibgen8_in.10 DC 0
V120 __resumption_tag.11 zll_main_fibgen8_in.11 DC 0
V121 __resumption_tag.12 zll_main_fibgen8_in.12 DC 0
V122 __resumption_tag.13 zll_main_fibgen8_in.13 DC 0
V123 __resumption_tag.14 zll_main_fibgen8_in.14 DC 0
V124 __resumption_tag.15 zll_main_fibgen8_in.15 DC 0
V125 __in0 zll_main_fibgen_in.0 DC 0
V126 __resumption_tag.0 zll_main_fibgen_in.1 DC 0
V127 __resumption_tag.1 zll_main_fibgen_in.2 DC 0
V128 __resumption_tag.2 zll_main_fibgen_in.3 DC 0
V129 __resumption_tag.3 zll_main_fibgen_in.4 DC 0
V130 __resumption_tag.4 zll_main_fibgen_in.5 DC 0
V131 __resumption_tag.5 zll_main_fibgen_in.6 DC 0
V132 __resumption_tag.6 zll_main_fibgen_in.7 DC 0
V133 __resumption_tag.7 zll_main_fibgen_in.8 DC 0
V134 __in0 zll_main_fibgen_in.9 DC 0
V135 __resumption_tag.8 zll_main_fibgen_in.10 DC 0
V136 __resumption_tag.9 zll_main_fibgen_in.11 DC 0
V137 __resumption_tag.10 zll_main_fibgen_in.12 DC 0
V138 __resumption_tag.11 zll_main_fibgen_in.13 DC 0
V139 __resumption_tag.12 zll_main_fibgen_in.14 DC 0
V140 __resumption_tag.13 zll_main_fibgen_in.15 DC 0
V141 __resumption_tag.14 zll_main_fibgen_in.16 DC 0
V142 __resumption_tag.15 zll_main_fibgen_in.17 DC 0
V143 __resumption_tag.0 zll_pure_dispatch1_in.0 DC 0
V144 __resumption_tag.1 zll_pure_dispatch1_in.1 DC 0
V145 __resumption_tag.2 zll_pure_dispatch1_in.2 DC 0
V146 __resumption_tag.3 zll_pure_dispatch1_in.3 DC 0
V147 __resumption_tag.4 zll_pure_dispatch1_in.4 DC 0
V148 __resumption_tag.5 zll_pure_dispatch1_in.5 DC 0
V149 __resumption_tag.6 zll_pure_dispatch1_in.6 DC 0
V150 __resumption_tag.7 zll_pure_dispatch1_in.7 DC 0
V151 __resumption_tag.8 zll_pure_dispatch1_in.8 DC 0
V152 __resumption_tag.9 zll_pure_dispatch1_in.9 DC 0
V153 __resumption_tag.10 zll_pure_dispatch1_in.10 DC 0
V154 __resumption_tag.11 zll_pure_dispatch1_in.11 DC 0
V155 __resumption_tag.12 zll_pure_dispatch1_in.12 DC 0
V156 __resumption_tag.13 zll_pure_dispatch1_in.13 DC 0
V157 __resumption_tag.14 zll_pure_dispatch1_in.14 DC 0
V158 __resumption_tag.15 zll_pure_dispatch1_in.15 DC 0
V159 __in0 zll_pure_dispatch1_in.16 DC 0
V160 __resumption_tag.0 zll_pure_dispatch_in.0 DC 0
V161 __resumption_tag.1 zll_pure_dispatch_in.1 DC 0
V162 __resumption_tag.2 zll_pure_dispatch_in.2 DC 0
V163 __resumption_tag.3 zll_pure_dispatch_in.3 DC 0
V164 __resumption_tag.4 zll_pure_dispatch_in.4 DC 0
V165 __resumption_tag.5 zll_pure_dispatch_in.5 DC 0
V166 __resumption_tag.6 zll_pure_dispatch_in.6 DC 0
V167 __resumption_tag.7 zll_pure_dispatch_in.7 DC 0
V168 __in0 zll_pure_dispatch_in.8 DC 0
V169 __resumption_tag.8 zll_pure_dispatch_in.9 DC 0
V170 __resumption_tag.9 zll_pure_dispatch_in.10 DC 0
V171 __resumption_tag.10 zll_pure_dispatch_in.11 DC 0
V172 __resumption_tag.11 zll_pure_dispatch_in.12 DC 0
V173 __resumption_tag.12 zll_pure_dispatch_in.13 DC 0
V174 __resumption_tag.13 zll_pure_dispatch_in.14 DC 0
V175 __resumption_tag.14 zll_pure_dispatch_in.15 DC 0
V176 __resumption_tag.15 zll_pure_dispatch_in.16 DC 0

************************
* end of SPICE netlist *
************************
